.subckt dd2_gc1__o22ai_1 A B C D VGND VNB VPB VPWR Y
X0 Y A n1 VNB sky130_fd_pr__nfet_01v8 w=0.65 l=0.15
X1 Y B n1 VNB sky130_fd_pr__nfet_01v8 w=0.65 l=0.15
X2 n1 C VGND VNB sky130_fd_pr__nfet_01v8 w=0.65 l=0.15
X3 n1 D VGND VNB sky130_fd_pr__nfet_01v8 w=0.65 l=0.15
X4 Y A p1 VPB sky130_fd_pr__pfet_01v8_hvt w=1 l=0.15
X5 p1 B VPWR VPB sky130_fd_pr__pfet_01v8_hvt w=1 l=0.15
X6 Y C p2 VPB sky130_fd_pr__pfet_01v8_hvt w=1 l=0.15
X7 p2 D VPWR VPB sky130_fd_pr__pfet_01v8_hvt w=1 l=0.15
.ends
