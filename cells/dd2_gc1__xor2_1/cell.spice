.subckt dd2_gc1__xor2_1 A B VGND VNB VPB VPWR Y
X0 A_b A VGND VNB sky130_fd_pr__nfet_01v8 w=0.65 l=0.15
X1 A_b A VPWR VPB sky130_fd_pr__pfet_01v8_hvt w=1 l=0.15
X2 B_b B VGND VNB sky130_fd_pr__nfet_01v8 w=0.65 l=0.15
X3 B_b B VPWR VPB sky130_fd_pr__pfet_01v8_hvt w=1 l=0.15
X4 Y A n1 VNB sky130_fd_pr__nfet_01v8 w=0.65 l=0.15
X5 n1 B VGND VNB sky130_fd_pr__nfet_01v8 w=0.65 l=0.15
X6 Y A_b n2 VNB sky130_fd_pr__nfet_01v8 w=0.65 l=0.15
X7 n2 B_b VGND VNB sky130_fd_pr__nfet_01v8 w=0.65 l=0.15
X8 Y A_b p1 VPB sky130_fd_pr__pfet_01v8_hvt w=1 l=0.15
X9 Y B_b p1 VPB sky130_fd_pr__pfet_01v8_hvt w=1 l=0.15
X10 p1 A VPWR VPB sky130_fd_pr__pfet_01v8_hvt w=1 l=0.15
X11 p1 B VPWR VPB sky130_fd_pr__pfet_01v8_hvt w=1 l=0.15
.ends
