.subckt dd2_gc1__and2_1 A B VGND VNB VPB VPWR Y
X0 Y_b A n1 VNB sky130_fd_pr__nfet_01v8 w=0.65 l=0.15
X1 n1 B VGND VNB sky130_fd_pr__nfet_01v8 w=0.65 l=0.15
X2 Y_b A VPWR VPB sky130_fd_pr__pfet_01v8_hvt w=1 l=0.15
X3 Y_b B VPWR VPB sky130_fd_pr__pfet_01v8_hvt w=1 l=0.15
X4 Y Y_b VGND VNB sky130_fd_pr__nfet_01v8 w=0.65 l=0.15
X5 Y Y_b VPWR VPB sky130_fd_pr__pfet_01v8_hvt w=1 l=0.15
.ends
