.subckt dd2_gc1__f001f_1 A B C D VGND VNB VPB VPWR Y
X0 Y D VGND VNB sky130_fd_pr__nfet_01v8 w=0.65 l=0.15
X1 Y C n1 VNB sky130_fd_pr__nfet_01v8 w=0.65 l=0.15
X2 n1 A VGND VNB sky130_fd_pr__nfet_01v8 w=0.65 l=0.15
X3 n1 B VGND VNB sky130_fd_pr__nfet_01v8 w=0.65 l=0.15
X4 Y C p1 VPB sky130_fd_pr__pfet_01v8_hvt w=1 l=0.15
X5 Y A p2 VPB sky130_fd_pr__pfet_01v8_hvt w=1 l=0.15
X6 p2 B p1 VPB sky130_fd_pr__pfet_01v8_hvt w=1 l=0.15
X7 p1 D VPWR VPB sky130_fd_pr__pfet_01v8_hvt w=1 l=0.15
.ends
