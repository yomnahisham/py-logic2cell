.subckt dd2_gc1__f011f_1 A B C D VGND VNB VPB VPWR Y
X0 Y C n1 VNB sky130_fd_pr__nfet_01v8 w=0.65 l=0.15
X1 n1 D VGND VNB sky130_fd_pr__nfet_01v8 w=0.65 l=0.15
X2 Y A n2 VNB sky130_fd_pr__nfet_01v8 w=0.65 l=0.15
X3 Y B n2 VNB sky130_fd_pr__nfet_01v8 w=0.65 l=0.15
X4 n2 C VGND VNB sky130_fd_pr__nfet_01v8 w=0.65 l=0.15
X5 n2 D VGND VNB sky130_fd_pr__nfet_01v8 w=0.65 l=0.15
X6 Y A p2 VPB sky130_fd_pr__pfet_01v8_hvt w=1 l=0.15
X7 p2 B p1 VPB sky130_fd_pr__pfet_01v8_hvt w=1 l=0.15
X8 Y C p3 VPB sky130_fd_pr__pfet_01v8_hvt w=1 l=0.15
X9 p3 D p1 VPB sky130_fd_pr__pfet_01v8_hvt w=1 l=0.15
X10 p1 C VPWR VPB sky130_fd_pr__pfet_01v8_hvt w=1 l=0.15
X11 p1 D VPWR VPB sky130_fd_pr__pfet_01v8_hvt w=1 l=0.15
.ends
