.subckt dd2_gc1__or_and_maj A B C D VGND VNB VPB VPWR Y
X0 Y_b C n1 VNB sky130_fd_pr__nfet_01v8 w=0.65 l=0.15
X1 n1 D VGND VNB sky130_fd_pr__nfet_01v8 w=0.65 l=0.15
X2 Y_b A n2 VNB sky130_fd_pr__nfet_01v8 w=0.65 l=0.15
X3 n2 B n3 VNB sky130_fd_pr__nfet_01v8 w=0.65 l=0.15
X4 n3 C VGND VNB sky130_fd_pr__nfet_01v8 w=0.65 l=0.15
X5 n3 D VGND VNB sky130_fd_pr__nfet_01v8 w=0.65 l=0.15
X6 Y_b C p1 VPB sky130_fd_pr__pfet_01v8_hvt w=1 l=0.15
X7 Y_b D p1 VPB sky130_fd_pr__pfet_01v8_hvt w=1 l=0.15
X8 p1 A VPWR VPB sky130_fd_pr__pfet_01v8_hvt w=1 l=0.15
X9 p1 B VPWR VPB sky130_fd_pr__pfet_01v8_hvt w=1 l=0.15
X10 p1 C p2 VPB sky130_fd_pr__pfet_01v8_hvt w=1 l=0.15
X11 p2 D VPWR VPB sky130_fd_pr__pfet_01v8_hvt w=1 l=0.15
X12 Y Y_b VGND VNB sky130_fd_pr__nfet_01v8 w=0.65 l=0.15
X13 Y Y_b VPWR VPB sky130_fd_pr__pfet_01v8_hvt w=1 l=0.15
.ends
