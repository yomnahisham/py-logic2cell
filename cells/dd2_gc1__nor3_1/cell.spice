.subckt dd2_gc1__nor3_1 A B C VGND VNB VPB VPWR Y
X0 Y A VGND VNB sky130_fd_pr__nfet_01v8 w=0.65 l=0.15
X1 Y B VGND VNB sky130_fd_pr__nfet_01v8 w=0.65 l=0.15
X2 Y C VGND VNB sky130_fd_pr__nfet_01v8 w=0.65 l=0.15
X3 Y A p1 VPB sky130_fd_pr__pfet_01v8_hvt w=1 l=0.15
X4 p1 B p2 VPB sky130_fd_pr__pfet_01v8_hvt w=1 l=0.15
X5 p2 C VPWR VPB sky130_fd_pr__pfet_01v8_hvt w=1 l=0.15
.ends
