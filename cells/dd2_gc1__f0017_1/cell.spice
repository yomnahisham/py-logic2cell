.subckt dd2_gc1__f0017_1 A B C D VGND VNB VPB VPWR Y
X0 Y D VGND VNB sky130_fd_pr__nfet_01v8 w=0.65 l=0.15
X1 Y C n1 VNB sky130_fd_pr__nfet_01v8 w=0.65 l=0.15
X2 Y A n2 VNB sky130_fd_pr__nfet_01v8 w=0.65 l=0.15
X3 n2 B n1 VNB sky130_fd_pr__nfet_01v8 w=0.65 l=0.15
X4 n1 A VGND VNB sky130_fd_pr__nfet_01v8 w=0.65 l=0.15
X5 n1 B VGND VNB sky130_fd_pr__nfet_01v8 w=0.65 l=0.15
X6 Y D p1 VPB sky130_fd_pr__pfet_01v8_hvt w=1 l=0.15
X7 p1 A p2 VPB sky130_fd_pr__pfet_01v8_hvt w=1 l=0.15
X8 p2 B VPWR VPB sky130_fd_pr__pfet_01v8_hvt w=1 l=0.15
X9 p1 C p3 VPB sky130_fd_pr__pfet_01v8_hvt w=1 l=0.15
X10 p3 A VPWR VPB sky130_fd_pr__pfet_01v8_hvt w=1 l=0.15
X11 p3 B VPWR VPB sky130_fd_pr__pfet_01v8_hvt w=1 l=0.15
.ends
